** sch_path: /home/thilak-t/Desktop/projects/Dram/1t1c_dram.sch
**.subckt 1t1c_dram bl cs wl vdd blb
*.ipin bl
*.ipin cs
*.ipin wl
*.ipin vdd
*.ipin blb
XM1 bl cs wl gnd sky130_fd_pr__nfet_01v8 L=0.15 W=1 nf=1 ad=0.29 as=0.29 pd=2.58 ps=2.58 nrd=0.29 nrs=0.29 sa=0 sb=0 sd=0 mult=1
C1 bl gnd 200f
C2 wl gnd 200f
C3 cs gnd 30f
XM2 cs blb vdd vdd sky130_fd_pr__pfet_01v8 L=0.15 W=1.5 nf=1 ad=0.435 as=0.435 pd=3.58 ps=3.58 nrd=0.193333333333333
+ nrs=0.193333333333333 sa=0 sb=0 sd=0 mult=1
XM3 cs blb gnd gnd sky130_fd_pr__nfet_01v8 L=0.15 W=1 nf=1 ad=0.29 as=0.29 pd=2.58 ps=2.58 nrd=0.29 nrs=0.29 sa=0 sb=0 sd=0 mult=1
XM4 blb cs vdd vdd sky130_fd_pr__pfet_01v8 L=0.15 W=1.5 nf=1 ad=0.435 as=0.435 pd=3.58 ps=3.58 nrd=0.193333333333333
+ nrs=0.193333333333333 sa=0 sb=0 sd=0 mult=1
XM5 blb cs gnd gnd sky130_fd_pr__nfet_01v8 L=0.15 W=1 nf=1 ad=0.29 as=0.29 pd=2.58 ps=2.58 nrd=0.29 nrs=0.29 sa=0 sb=0 sd=0 mult=1
V1 vdd gnd dc 1.8
V2 wl gnd dc 0
V3 bl gnd dc 0.9
V4 cs gnd dc 0
**** begin user architecture code
.lib /home/thilak-t/Desktop/eda_tools/open_pdks/sky130/sky130A/libs.tech/combined/sky130.lib.spice tt

.IC V(cs)=0 V(blb)=1.8

.control
  DC V4 0 1.8 0.005
  DC V5 0 1.8 0.005
  plot v(blb) vs v(cs) v(cs) vs v(blb)
  meas dc Vtrip when V(blb)=V(cs) rise=1
.endc

**** end user architecture code
**.ends
.GLOBAL gnd
.end
