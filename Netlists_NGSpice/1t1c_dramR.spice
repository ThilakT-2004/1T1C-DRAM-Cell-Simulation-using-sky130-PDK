** sch_path: /home/thilak-t/Desktop/projects/Dram/1t1c_dramR.sch
**.subckt 1t1c_dramR bl cs wl vdd blb
*.ipin bl
*.ipin cs
*.ipin wl
*.ipin vdd
*.ipin blb
XM1 bl cs wl gnd sky130_fd_pr__nfet_01v8 L=0.15 W=1 nf=1 ad=0.29 as=0.29 pd=2.58 ps=2.58 nrd=0.29 nrs=0.29 sa=0 sb=0 sd=0 mult=1
C1 bl gnd 200f
C3 cs gnd 30f
XM2 cs blb vdd vdd sky130_fd_pr__pfet_01v8 L=0.15 W=1.5 nf=1 ad=0.435 as=0.435 pd=3.58 ps=3.58 nrd=0.193333333333333
+ nrs=0.193333333333333 sa=0 sb=0 sd=0 mult=1
XM3 cs blb gnd gnd sky130_fd_pr__nfet_01v8 L=0.15 W=1 nf=1 ad=0.29 as=0.29 pd=2.58 ps=2.58 nrd=0.29 nrs=0.29 sa=0 sb=0 sd=0 mult=1
XM4 blb cs vdd vdd sky130_fd_pr__pfet_01v8 L=0.15 W=1.5 nf=1 ad=0.435 as=0.435 pd=3.58 ps=3.58 nrd=0.193333333333333
+ nrs=0.193333333333333 sa=0 sb=0 sd=0 mult=1
XM5 blb cs gnd gnd sky130_fd_pr__nfet_01v8 L=0.15 W=1 nf=1 ad=0.29 as=0.29 pd=2.58 ps=2.58 nrd=0.29 nrs=0.29 sa=0 sb=0 sd=0 mult=1
V1 vdd gnd dc 1.8
V2 wl gnd PULSE(0 1.8 5n 0.1n 0.1n 30n 60n)
V3 bl gnd dc 0.9
C4 blb gnd 200f
R1 bl gnd 1T
R2 blb gnd 10k
**** begin user architecture code
.lib /home/thilak-t/Desktop/eda_tools/open_pdks/sky130/sky130A/libs.tech/combined/sky130.lib.spice tt

.IC V(cs)=1.35  V(bl)=0.9  V(blb)=0.9

.control
  tran 0.01n 80n
  plot V(wl) V(bl) V(blb) V(cs)
  meas tran delta_V    find V(bl) at=6n
  meas tran t_sense    trig V(bl)  val=0.85 fall=1  targ V(cs) val=0.2 fall=1
.endc

**** end user architecture code
**.ends
.GLOBAL gnd
.end
